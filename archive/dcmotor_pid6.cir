* dcmotor_pid6.cir
* PMDC motor speed control - PI controller + PWM
*
* ============================================================
* MATHEMATICAL VERIFICATION (all checked with Python)
* ============================================================
*
* A) ELECTRICAL CIRCUIT (KVL)
*    Topology: Vsup -> Ssw -> arm -> Vmeas -> a_meas -> Rarm -> a1 -> La -> a2 -> Eemf -> 0
*    KVL: Vbus = Ia*Ra + La*dIa/dt + Ke*omega
*    'Eemf a2 0': V(a2)-V(0) = +Ke*omega -> Ia drops as omega rises (braking) OK
*
* B) SIGN OF I(Vmeas)
*    'Vmeas arm a_meas DC 0': + terminal is arm
*    ngspice: I(V) positive = current entering the + terminal
*    In normal operation current flows arm->a_meas, so I(Vmeas) = +Ia OK
*
* C) MECHANICAL MODEL
*    J * dOmega/dt = Kt*Ia - Bm*Omega - Tload
*    'Baccel 0 omega': current 0->omega (enters the omega node)
*    'Comega omega 0 {J}': positive node = omega
*    => J * dV(omega)/dt = Kt*I(Vmeas) - Bm*V(omega) - Tload OK
*
* D) FREEWHEEL DIODE
*    When the switch opens the La current continues: a1->a2->Eemf->0->Dfw->arm->...
*    Current from 0 to arm is needed => anode=0, cathode=arm => 'Dfw 0 arm' OK
*
* E) PWM GENERATOR
*    Ramp peak = Iramp*Tperiod/Cramp = 600u*200u/10n = 12V = Vctrl_high OK
*
* F) PI CONTROLLER
*    nd_prop = Kp*err
*    C*dV(nd_int)/dt = Ki*err => V(nd_int) = Ki*integral(err)dt  (C=1F)
*    nd_raw = nd_prop + nd_int = Kp*err + Ki*integral(err)dt OK
*    Vsat = limit(nd_raw, 0, 12) OK
*    WARNING: 'int' is a reserved word in ngspice! It cannot be used as a node name.
*             All PI nodes are defined with the nd_ prefix.
*
* G) STEADY STATE
*    Ia_ss = Bm*omega_ref/Kt = 1e-4*314/0.02 = 1.57 A
*    Va_ss = Ia_ss*Ra + Ke*omega_ref = 7.065 V
*    Duty_ss = Va_ss/Vbus = 29.4%
*    Vsat_ss = duty_ss * Vctrl_high = 3.53 V
*    V(nd_int)_ss ~ 7.07 V (as error->0, prop->0 and the integral holds Va_ss)
*    Kp*err0 = 0.05*314 = 15.7V > 12V -> full duty at start OK
*
* ============================================================

.tran 5u 2 uic

* --- Parameters ---
.param Vbus     = 24
.param fsw      = 5000
.param Tperiod  = { 1/fsw }

* Motor
.param Ke   = 0.02
.param Kt   = 0.02
.param Ra   = 0.5
.param La   = 2e-3
.param J    = 1e-4
.param Bm   = 1e-4
.param Tload= 0

* PI
.param Kp   = 0.05
.param Ki   = 2

* PWM
.param Vctrl_high = 12
.param Vctrl_thr  = 2.5
.param Iramp  = 600u
.param Cramp  = 10n

* ---------------------------------------------------------------
* NUMERICAL SOLVER
* ---------------------------------------------------------------
.options method=gear
+        reltol=1e-3
+        abstol=1e-6
+        vntol=1e-4
+        itl4=150
+        maxstep=10u

* ---------------------------------------------------------------
* POWER AND SWITCHING
* ---------------------------------------------------------------
Vsup  Vsup_node 0  DC {Vbus}

* Low-side switch: Vsup_node -> arm
Ssw  Vsup_node  arm  gate  0  SWmod
.model SWmod SW(Ron=0.01 Roff=1Meg Vt={Vctrl_thr})

* ---------------------------------------------------------------
* ARMATURE CIRCUIT
* ---------------------------------------------------------------
* I(Vmeas) = +Ia (arm is the + terminal, current flows in) OK
Vmeas  arm  a_meas  DC 0

Rarm  a_meas  a1  {Ra}
La    a1      a2  {La}

* V(a2) = +Ke*omega -> braking OK
Eemf  a2  0  VALUE = { Ke * V(omega) }

* Freewheeling: conducts in the 0->arm direction OK
Dfw  0  arm  Dmod
.model Dmod D(Is=1e-9 Rs=0.05)

* ---------------------------------------------------------------
* MECHANICAL MODEL
* ---------------------------------------------------------------
* J * dOmega/dt = Kt*Ia - Bm*Omega - Tload
* Baccel 0->omega: current enters the omega node, V(omega) rises OK
Baccel  0  omega  I = { Kt * I(Vmeas) - Bm * V(omega) - Tload }
Comega  omega  0  {J}

* ---------------------------------------------------------------
* PI CONTROLLER
* NOTE: 'int' is a reserved word in ngspice, nd_int is used instead
* ---------------------------------------------------------------
Vref  ref  0  DC 314

* Error
Berr  err  0  V = { V(ref) - V(omega) }

* Proportional term
Bprop  nd_prop  0  V = { Kp * V(err) }

* Integral term: Cint * dV/dt = Ki*err => V(nd_int) = Ki * integral(err)
Bi_int  nd_int  0  I = { Ki * V(err) }
Cint    nd_int  0  1

* Raw PI output
Bpid_raw  nd_raw  0  V = { V(nd_prop) + V(nd_int) }

* Saturation [0, Vctrl_high]
Bsat  Vsat  0  V = { limit( V(nd_raw), 0, Vctrl_high ) }

* ---------------------------------------------------------------
* PWM GENERATOR
* Peak = 600u * 200u / 10n = 12V = Vctrl_high OK
* ---------------------------------------------------------------
Bi_ramp  rnode  0  I = { Iramp }
Cramp    rnode  0  {Cramp}

* Reset: 100n rise/fall, 300n pulse width
Vreset  rtrig  0  PULSE(0 {Vctrl_high} 0 100n 100n 300n {Tperiod})
Sres  rnode  0  rtrig  0  SWres
.model SWres SW(Ron=0.1 Roff=1Meg Vt=2)

* ---------------------------------------------------------------
* GATE SIGNAL
* Vsat > ramp -> gate=12V -> switch closes OK
* ---------------------------------------------------------------
Bgate  gate  0  V = { Vctrl_high * ( V(Vsat) > V(rnode) ) }

* ---------------------------------------------------------------
* INITIAL CONDITIONS
* ---------------------------------------------------------------
.ic V(omega)=0  V(nd_int)=0  V(rnode)=0

* ---------------------------------------------------------------
* SIMULATION
* ---------------------------------------------------------------
.control
  set noaskquit
  run

  save time V(omega) V(err) V(nd_int) V(nd_prop) V(nd_raw) V(Vsat) V(rnode) V(gate)
  wrdata dcmotor_out6.csv time V(omega) V(err) V(nd_int) V(nd_prop) V(nd_raw) V(Vsat) V(gate)

.endc

.end
